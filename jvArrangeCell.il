procedure(jvArrangeCell()

cell=geGetSelSet()

foreach(x cell

	if(rexMatchp("I11(0)" "I11(0)")             ;buildString('(x~>name)))
	    printf("Matched")
	);if

	else(
		printf("Unmatched")
	)

);foreach

);procedure
